[IBIS Ver]   3.2
[File Name]   a9125_2012aprv00.ibs
[File Rev]   1.00
[Date]   03/06/2012
[Source]   From silicon level SPICE model
[Notes]
[Disclaimer]
|Use:DMP Electronics INC. ("DMP") hereby grants the user of this
|IBIS model ("user") non-exclusive, nontransferable license to use the
|model under the following terms. User may only use the IBIS model and
|is not granted rights to sell, copy, rent, lease or sub-license the IBIS
|model in whole or in part, or in modified form to anyone.
|DISCLAIMER OF WARRANTY: ALL ACCOMPANYING MATERIALS ARE PROVIDED "AS IS",
|WITHOUT WARRANTY OF ANY KIND. TO THE MAXIMUM EXTENT PERMITTED BY LAW,
|DMP HEREBY DISCLAIMS ALL WARRANTIES, EXPRESS, IMPLIED AND STATUTORY,
|INCLUDING BUT NOT LIMITED TO, IMPLIED WARRANTIES OF MERCHANTABILITY AND
|FITNESS FOR A PARTICULAR PURPOSE (REGARDLESS OF WHETHER DMP KNOWS OF
|SUCH PURPOSE) AND AGAINST INFRINGEMENT. THE ENTIRE RISK ARISING OUT OF
|THE USE OR PERFORMANCE OF ANY ACCOMPANYING WRITTEN MATERIALS REMAINS
|WITH USER.
[Copyright]
|This file is the legal property of DMP Electronics INC. All other
|rights are reserved.
[Component]   A9125
[Manufacturer]  DMP Electronics INC.
[Package]
|   typ   min   max
R_pkg	0.377	0.264	0.538
L_pkg	7.123nH	4.986nH	10.175nH
C_pkg	1.883pF	1.318pF	2.690pF
[Pin]	signal_name	model_name	R_pin	L_pin	C_pin
F6	pCLK25MOUT1	IO3_EB
AB30	pCLK25MOUT2	IO3_EB
AD30	pCLK24MOUT	IO3_EB
H6	pVGACLK14M	IO3_EB
M3	pPOWER_GOOD	IO2_EB
AB29	pSPEAKER	IO3_EB
AA30	pSYSFAIL_	IO2_EB
W28	pExtSysFailIn_	IO2_EB
Y29	pExt_Switch_fail	IO2_EB
U21	pEXT_GPCS_	IO2_EB
C2	pPCIRST_	IO1_EB
L27	GPIO_P0[7]	IO2_EB
L26	GPIO_P0[6]	IO2_EB
P27	GPIO_P0[5]	IO2_EB
J26	GPIO_P0[4]	IO2_EB
N27	GPIO_P0[3]	IO2_EB
M25	GPIO_P0[2]	IO2_EB
M26	GPIO_P0[1]	IO2_EB
N25	GPIO_P0[0]	IO2_EB
B6	GPIO_P1[7]	IO2_EB
D6	GPIO_P1[6]	IO2_EB
E8	GPIO_P1[5]	IO2_EB
A6	GPIO_P1[4]	IO2_EB
C6	GPIO_P1[3]	IO2_EB
F7	GPIO_P1[2]	IO2_EB
E6	GPIO_P1[1]	IO2_EB
E5	GPIO_P1[0]	IO2_EB
F23	GPIO_P2[7]	IO2_EB
G25	GPIO_P2[6]	IO2_EB
E27	GPIO_P2[5]	IO2_EB
F26	GPIO_P2[4]	IO2_EB
E26	GPIO_P2[3]	IO2_EB
E23	GPIO_P2[2]	IO2_EB
F24	GPIO_P2[1]	IO2_EB
F22	GPIO_P2[0]	IO2_EB
H3	GPIO_P3[3]	IO2_EB
E1	GPIO_P3[2]	IO2_EB
G2	GPIO_P3[1]	IO2_EB
F1	GPIO_P3[0]	IO2_EB
K12	GPIO_P6[7]	IO2_EB
K13	GPIO_P6[6]	IO2_EB
F4	GPIO_P6[5]	IO2_EB
G4	GPIO_P6[4]	IO2_EB
E4	GPIO_P6[3]	IO2_EB
L12	GPIO_P6[2]	IO2_EB
H4	GPIO_P6[1]	IO2_EB
L13	GPIO_P6[0]	IO2_EB
C5	GPIO_P7[7]	IO2_EB
D5	GPIO_P7[6]	IO2_EB
A4	GPIO_P7[5]	IO2_EB
B4	GPIO_P7[4]	IO2_EB
A3	GPIO_P7[3]	IO2_EB
B3	GPIO_P7[2]	IO2_EB
A5	GPIO_P7[1]	IO2_EB
C4	GPIO_P7[0]	IO2_EB
F13	GPIO_P8[7]	IO2_EB
F12	GPIO_P8[6]	IO2_EB
F11	GPIO_P8[5]	IO2_EB
E9	GPIO_P8[4]	IO2_EB
F9	GPIO_P8[3]	IO2_EB
F10	GPIO_P8[2]	IO2_EB
F8	GPIO_P8[1]	IO2_EB
E11	GPIO_P8[0]	IO2_EB
G27	GPIO_P9[7]	IO2_EB
J25	GPIO_P9[6]	IO2_EB
G26	GPIO_P9[5]	IO2_EB
H25	GPIO_P9[4]	IO2_EB
H27	GPIO_P9[3]	IO2_EB
J27	GPIO_P9[2]	IO2_EB
K26	GPIO_P9[1]	IO2_EB
K25	GPIO_P9[0]	IO2_EB
L14	GPIO_PA[7]	IO2_EB
K14	GPIO_PA[6]	IO2_EB
L15	GPIO_PA[5]	IO2_EB
E14	GPIO_PA[4]	IO2_EB
K15	GPIO_PA[3]	IO2_EB
F14	GPIO_PA[2]	IO2_EB
K16	GPIO_PA[1]	IO2_EB
F15	GPIO_PA[0]	IO2_EB
K11	pSPI_CS_ROM_CS	IO3_EB
L10	pSPI_CK		IO3_EB
L11	pSPI_DO		IO3_EB
K10	pSPI_DI		IO3_EB
U28	pRSET		IO2_EB
V26	pGPCS0_		IO2_EB
AD25	pGPCS1_		IO2_EB
AE24	pOSC14M		IO2_EB
AA25	pATCLK		IO2_EB
AC29	pLA[23]		IO2_EB
AE29	pLA[22]		IO2_EB
AD28	pLA[21]		IO2_EB
AE30	pLA[20]		IO2_EB
AF29	pLA[19]		IO2_EB
AE28	pLA[18]		IO2_EB
AF30	pLA[17]		IO2_EB
AG30	pSA[19]		IO2_EB
AG29	pSA[18]		IO2_EB
AD27	pSA[17]		IO2_EB
AF28	pSA[16]		IO2_EB
AH30	pSA[15]		IO2_EB
AJ29	pSA[14]		IO2_EB
AF27	pSA[13]		IO2_EB
AK29	pSA[12]		IO2_EB
AG28	pSA[11]		IO2_EB
AJ30	pSA[10]		IO2_EB
AG27	pSA[9]		IO2_EB
AJ28	pSA[8]		IO2_EB
AH28	pSA[7]		IO2_EB
AK28	pSA[6]		IO2_EB
AJ27	pSA[5]		IO2_EB
AH26	pSA[4]		IO2_EB
AK27	pSA[3]		IO2_EB
AK25	pSA[2]		IO2_EB
AJ26	pSA[1]		IO2_EB
AK26	pSA[0]		IO2_EB
V21	pSBHE_		IO2_EB
W26	pXD[15]		IO2_EB
AA27	pXD[14]		IO2_EB
V27	pXD[13]		IO2_EB
AJ20	pXD[12]		IO2_EB
AH21	pXD[11]		IO2_EB
AG21	pXD[10]		IO2_EB
AH22	pXD[9]		IO2_EB
AG22	pXD[8]		IO2_EB
AK23	pXD[7]		IO2_EB
AK22	pXD[6]		IO2_EB
AH23	pXD[5]		IO2_EB
AJ23	pXD[4]		IO2_EB
AH24	pXD[3]		IO2_EB
AG24	pXD[2]		IO2_EB
AK24	pXD[1]		IO2_EB
AJ24	pXD[0]		IO2_EB
AG26	pMEMR_		IO2_EB
AB25	pMEMW_		IO2_EB
V20	pSMEMR_		IO2_EB
Y27	pSMEMW_		IO2_EB
T21	pIOR_		IO2_EB
T20	pIOW_	 	IO2_EB
W20	pTC   IO2_EB
AD26	pDREQ0		IO2_EB
AF26	pDREQ1		IO2_EB
AE23	pDREQ2		IO2_EB
Y21	pDREQ3		IO2_EB
AE26	pDREQ5		IO2_EB
W21	pDREQ6		IO2_EB
AC27	pDREQ7		IO2_EB
AG23	pIRQ3 		IO2_EB
AF22	pIRQ4 		IO2_EB
W25	pIRQ5 		IO2_EB
Y28	pIRQ6 		IO2_EB
AA28	pIRQ7 		IO2_EB
AE22	pIRQ9 		IO2_EB
AB26	pIRQ10		IO2_EB
U27	pIRQ11		IO2_EB
AC26	pIRQ12		IO2_EB
AC28	pIRQ14		IO2_EB
AB27	pIRQ15		IO2_EB
Y20	pIOCHRDY	IO2_EB
T27	pDACK0_		IO2_EB
AH25	pDACK1_		IO2_EB
AG25	pDACK2_		IO2_EB
AA29	pDACK3_		IO2_EB
AF23	pDACK5_		IO2_EB
U26	pDACK6_		IO2_EB
AE25	pDACK7_		IO2_EB
U20	pMEMCS16_	IO2_EB
U25	pIOCS16_	IO2_EB
AF24	pZERO_WAIT_	IO2_EB
Y25	pAEN		IO2_EB
AC25	pBALE		IO2_EB
W27	pIOCHCK_	IO2_EB
Y26	pREFRESH_	IO2_EB
N26	pSIN_GPIO	IO2_EB
R26	pSOUT_GPIO	IO2_EB
R27	pRTS_GPIO	IO2_EB
R25	pCTS_GPIO	IO2_EB
T26	pDSR_GPIO	IO2_EB
R28	pDCD_GPIO	IO2_EB
P25	pRI_GPIO_	IO2_EB
T25	pDTR_GPIO_	IO2_EB
E12	pDCD2_PWM0CLK_	IO2_EB
D15	pSOUT2_PWM0OUT	IO2_EB
D13	pRTS2_PWM1OUT_	IO2_EB
D14	pRI2_PWM1CLK_	IO2_EB
D10	pSIN2_PWM2CLK	IO2_EB
D11	pDTR2_PWM2OUT_	IO2_EB
D12	pDSR2_PWM0GATE_	IO2_EB
C11	pCTS2_PWM1GATE_	IO2_EB
D2	pRTC_AS_GPIO	IO2_EB
F2	pRTC_RD_GPIO_	IO2_EB
G3	pRTC_WR_GPIO_	IO2_EB
D1	pRTC_IRQ8_GPIO_	IO2_EB
C8	pKBCLK_KBRST_	IO2_EB
D8	pKBDATA_A20GATE_	IO2_EB
C9	pMSCLK		IO2_EB
D9	pMSDATA		IO2_EB
K1	TXD0_0		IO3_EB
H1	TXD0_1		IO3_EB
G1	TXD0_2		IO3_EB
J1	TXD0_3		IO3_EB
J6	TXEN0		IO3_EB
L1	TXC0		IO3_EB
L2	RXC0		IO3_EB
J5	RXD0_0		IO3_EB
K4	RXD0_1		IO3_EB
J4	RXD0_2		IO3_EB
K3	RXD0_3		IO3_EB
L4	RXDV0		IO3_EB
L6	COL0		IO3_EB
K6	MDC1		IO3_EB
L5	MDIO1		IO3_EB
L3	LINK_LED	IO3_EB
J2	DPX_LED		IO3_EB
V30   TXOP_Main   SATA_TX_M
V29   TXON_Main   SATA_TX_M
| V30   TXOP_Boost   SATA_TX_B
| V29   TXON_Boost   SATA_TX_B
T30   RXIP   SATA_RX
T29   RXIN   SATA_RX
A20	pSATA_PHY_CLK_p	SATA_REFCLK
B20	pSATA_PHY_CLK_n	SATA_REFCLK
A22   PE0_TXP   PCIE_TX_M
B22   PE0_TXN   PCIE_TX_M
A24   PE0_RXP   PCIE_RX
B24   PE0_RXN   PCIE_RX
E25	PE0_CLKP	PCIE_REFCLK
E24	PE0_CLKN	PCIE_REFCLK
C27   PE1_TXP   PCIE_TX_M
D27   PE1_TXN   PCIE_TX_M
A26   PE1_RXP   PCIE_RX
B26   PE1_RXN   PCIE_RX
L30   USB1_DM   HSdriver_M
L29   USB1_DP   HSdriver_P
H30   USB2_DM   HSdriver_M
H29   USB2_DP   HSdriver_P
E30   USB3_DM   HSdriver_M
E29   USB3_DP   HSdriver_P
B30   USB4_DM   HSdriver_M
B29   USB4_DP   HSdriver_P
|AE6	OCDBIAS	BVCN3G
AF4	MD[0]	BBST
AF2	MD[1]	BBST
AF1	MD[2]	BBST
AG4	MD[3]	BBST
AF5	DQM[0]	BBST
AG2	DQS[0]	BBDT
AG3	DQS#[0]	BBDT
AG6	MD[4]	BBST
AH5	MD[5]	BBST
AH6	MD[6]	BBST
AH4	MD[7]	BBST
|AE11	VREF	0
AH2	MD[8]	BBST
AH1	MD[9]	BBST
AJ1	MD[10]	BBST
AJ2	MD[11]	BBST
AJ3	DQM[1]	BBST
AK4	DQS[1]	BBDT
AK3	DQS#[1]	BBDT
AJ5	MD[12]	BBST
AK6	MD[13]	BBST
AH7	MD[14]	BBST
AK7	MD[15]	BBST
AJ8	DRAMCLK	BODN
AK8	DRAMCLK#	BODN
AH8	MA[13]	BOST
AG8	MA[8]	BOST
AF8	MA[12]	BOST
AH9	MA[11]	BOST
AJ9	MA[4]	BOST
AK9	MA[7]	BOST
AF9	MA[14]	BOST
AG9	MA[6]	BOST
AH10	MA[2]	BOST
AJ10	MA[9]	BOST
AH11	MA[5]	BOST
AJ11	CAS#	BOST
AK11	MA[3]	BOST
AG11	MA[0]	BOST
AK12	MA[1]	BOST
AH12	MA[10]	BOST
AG12	RAS#	BOST
AF10	CS#[1]	BOST
AK13	BA[2]	BOST
AF13	ODT[1]	BOST
AE13	BA[1]	BOST
AH13	BA[0]	BOST
AF14	CKE	BOST
AJ13	WE#	BOST
AG14	ODT[0]	BOST
AE14	CS#[0]	BOST
AJ14	DRAMCLK1	BODN
AK14	DRAMCLK1#	BODN
AJ15	MD[16]	BBST
AH15	MD[17]	BBST
AK16	MD[18]	BBST
AH16	MD[19]	BBST
AH18	DQM[2]	BBST
AK17	DQS[2]	BBDT
AJ17	DQS#[2]	BBDT
AK18	MD[20]	BBST
AJ18	MD[21]	BBST
AK19	MD[22]	BBST
AH19	MD[23]	BBST
AG15	MD[24]	BBST
AF16	MD[25]	BBST
AG16	MD[26]	BBST
AG17	MD[27]	BBST
AE17	DQM[3]	BBST
AE18	DQS[3]	BBDT
AF18	DQS#[3]	BBDT
AG18	MD[28]	BBST
AG19	MD[29]	BBST
AE19	MD[30]	BBST
AF20	MD[31]	BBST
|AE21	OCDBIAS1	BVCN3G
|C2	PCIRST#	IO5
B1	GNT#[0]	IO1
A2	GNT#[1]	IO1
C1	GNT#[2]	IO1
E3	TCK	IN1
D3	TDI	IN1
F3	TDO	IO2
C3	TMS	IN1
|K10	SPI_DI	IO2
|L10	SPI_CLK	IO2
|L11	SPI_DO	IO2
|K11	SPI_CS#	IO2
|H3	E_SPI_DI	IO2
|G2	E_SPI_CLK	IO2
|E1	E_SPI_DO	IO2
|F1	E_SPI_CS#	IO2
|F6	I_XIN_25M	#N/A
|H6	G_XIN_14318	#N/A
|M3	PWRGOOD	IN1
|L6	COL	IN1
|K6	MDC	IO3
|L5	MDIO	IO2
|J5	RXD[0]	IN1
|K4	RXD[1]	IN1
|J4	RXD[2]	IN1
|K3	RXD[3]	IN1
|L4	RXDV	IN1
|L1	TXC	IN1
|K1	TXD[0]	IO2
|H1	TXD[1]	IO2
|G1	TXD[2]	IO2
|J1	TXD[3]	IO2
|J6	TXEN	IO2
|L2	RXC	IN1
|N1	G_IOR	APADRGB
|P1	G_IOG	APADRGB
|R1	G_IOB	APADRGB
|T1	G_REXT	APAD
AB4	G_VSYNC	IO4
V1	G_HSYNC	IO4
N5	G_GPIO[3]	IO2
N6	G_GPIO[2]	IO2
Y5	G_DDC_DAT	IO2
Y4	G_DDC_CLK	IO2
W3	G_DDC1_DAT	IO2
V3	G_DDC1_CLK	IO2
V5	G_TVCLKIN	IO2
U2	G_ENVEE	IO4
Y1	G_ENVDD	IO4
U3	G_FPD[23]	IO4
W1	G_FPD[22]	IO4
AA4	G_FPD[21]	IO4
T4	G_FPD[20]	IO4
V2	G_FPD[19]	IO4
AA6	G_FPD[18]	IO4
V6	G_FPD[17]	IO4
AA1	G_FPD[16]	IO4
AC5	G_FPD[15]	IO4
N4	G_FPD[14]	IO4
AA2	G_FPD[13]	IO4
AB3	G_FPD[12]	IO4
AB1	G_FPD[11]	IO4
W4	G_FPD[10]	IO4
U5	G_FPD[9]	IO4
AC3	G_FPD[8]	IO4
AC6	G_FPD[7]	IO4
Y3	G_FPD[6]	IO4
Y6	G_FPD[5]	IO4
AD3	G_FPD[4]	IO4
W5	G_FPD[3]	IO4
AB5	G_FPD[2]	IO4
AE2	G_FPD[1]	IO4
AC1	G_FPD[0]	IO4
AD4	G_ENBLT	IO4
AC4	G_FP1VS	IO4
AD1	G_FP1HS	IO4
AE4	G_FP1DET	IO4
U4	G_FP1DE	IO4
AD2	G_FP1CLK	IO4
[Diff Pin] inv_pin  vdiff   tdelay_typ tdelay_min tdelay_max
|SATA
V30   V29   NA   0   0   0
T30   T29   NA   0   0   0
A20   B20   NA   0   0   0
|PCIE
A22   B22   NA   0   0   0
A24   B24   NA   0   0   0
E25   E24   NA   0   0   0
C27   D27   NA   0   0   0
A26   B26   NA   0   0   0
|USB
L30   L29   360mV   0n   NA   NA
H30   H29   360mV   0n   NA   NA
E30   E29   360mV   0n   NA   NA
B30   B29   360mV   0n   NA   NA
[Model Selector] IO1_EB
WBT_MDDR_08MA  MDDR  8mA VDD=1.0V VDE=1.8V
WBT_MDDR_10MA  MDDR 10mA VDD=1.0V VDE=1.8V
WBT_MSDR_10MA  MSDR 10mA VDD=1.0V VDE=2.5V
WBT_MDDR_08MB  MDDR  8mA VDD=1.2V VDE=1.8V
WBT_MDDR_10MB  MDDR 10mA VDD=1.2V VDE=1.8V
WBT_MSDR_10MB  MSDR 10mA VDD=1.2V VDE=2.5V
[Model Selector] IO3_EB
IO3_A   IOL=4mA , FAST slew rate, Normal Output
IO3_B   IOL=4mA , SLOW slew rate, Normal Output
IO3_C   IOL=8mA , FAST slew rate, Normal Output
IO3_D   IOL=8mA , SLOW slew rate, Normal Output
IO3_E   IOL=12mA, FAST slew rate, Normal Output
IO3_F   IOL=12mA, SLOW slew rate, Normal Output
IO3_G   IOL=16mA, FAST slew rate, Normal Output
IO3_H   IOL=16mA, SLOW slew rate, Normal Output
IO3_I   IOL=4mA , FAST slew rate, Schmitt Output
IO3_J   IOL=4mA , SLOW slew rate, Schmitt Output
IO3_K   IOL=8mA , FAST slew rate, Schmitt Output
IO3_L   IOL=8mA , SLOW slew rate, Schmitt Output
IO3_M   IOL=12mA, FAST slew rate, Schmitt Output
IO3_N   IOL=12mA, SLOW slew rate, Schmitt Output
IO3_O   IOL=16mA, FAST slew rate, Schmitt Output
IO3_P   IOL=16mA, SLOW slew rate, Schmitt Output
[Model Selector] IO2_EB
IO2_A   IOL=4mA , FAST slew rate, Normal Input
IO2_B   IOL=4mA , SLOW slew rate, Normal Input
IO2_C   IOL=8mA , FAST slew rate, Normal Input
IO2_D   IOL=8mA , SLOW slew rate, Normal Input
IO2_E   IOL=12mA, FAST slew rate, Normal Input
IO2_F   IOL=12mA, SLOW slew rate, Normal Input
IO2_G   IOL=16mA, FAST slew rate, Normal Input
IO2_H   IOL=16mA, SLOW slew rate, Normal Input
IO2_I   IOL=4mA , FAST slew rate, Schmitt Input
IO2_J   IOL=4mA , SLOW slew rate, Schmitt Input
IO2_K   IOL=8mA , FAST slew rate, Schmitt Input
IO2_L   IOL=8mA , SLOW slew rate, Schmitt Input
IO2_M   IOL=12mA, FAST slew rate, Schmitt Input
IO2_N   IOL=12mA, SLOW slew rate, Schmitt Input
IO2_O   IOL=16mA, FAST slew rate, Schmitt Input
IO2_P   IOL=16mA, SLOW slew rate, Schmitt Input
[Model Selector] BBDT
BBDT3G		Target 28 & no ODT
BBDT3G_ODT		Target 28 & ODT w/t 150ohm
BBDT3G_ODT_S0		Target 28 & ODT w/t 75ohm
BBDT3G_ODT_S1		Target 28 & ODT w/t 50ohm
BBDT3G_T40		Target 40 & no ODT
BBDT3G_T40_ODT	Target 40 & ODT w/t 150ohm
BBDT3G_T40_ODT_S0	Target 40 & ODT w/t 75ohm
BBDT3G_T40_ODT_S1	Target 40 & ODT w/t 50ohm
BBDT3G_H 		Target 28 & no ODT & min OI
BBDT3G_H_ODT		Target 28 & ODT w/t 150ohm & min OI
BBDT3G_H_ODT_S0	Target 28 & ODT w/t 75ohm & min OI
BBDT3G_H_ODT_S1	Target 28 & ODT w/t 50ohm & min OI
BBDT3G_H_T40		Target 40 & no ODT & min OI
BBDT3G_H_T40_ODT	Target 40 & ODT w/t 150ohm & min OI
BBDT3G_H_T40_ODT_S0	Target 40 & ODT w/t 75ohm & min OI
BBDT3G_H_T40_ODT_S1	Target 40 & ODT w/t 50ohm & min OI
[Model Selector] BBST
BBST3G		Target 28 & no ODT
BBST3G_ODT		Target 28 & ODT w/t 150ohm
BBST3G_ODT_S0		Target 28 & ODT w/t 75ohm
BBST3G_ODT_S1		Target 28 & ODT w/t 50ohm
BBST3G_T40		Target 40 & no ODT
BBST3G_T40_ODT	Target 40 & ODT w/t 150ohm
BBST3G_T40_ODT_S0	Target 40 & ODT w/t 75ohm
BBST3G_T40_ODT_S1	Target 40 & ODT w/t 50ohm
BBST3G_H		Target 28 & no ODT & min OI
BBST3G_H_ODT		Target 28 & ODT w/t 150ohm & min OI
BBST3G_H_ODT_S0	Target 28 & ODT w/t 75ohm & min OI
BBST3G_H_ODT_S1	Target 28 & ODT w/t 50ohm & min OI
BBST3G_H_T40		Target 40 & no ODT & min OI
BBST3G_H_T40_ODT	Target 40 & ODT w/t 150ohm & min OI
BBST3G_H_T40_ODT_S0	Target 40 & ODT w/t 75ohm & min OI
BBST3G_H_T40_ODT_S1	Target 40 & ODT w/t 50ohm & min OI
[Model Selector] BODN
BODN3G		Target 28
BODN3G_T40		Target 40
BODN3G_H		Target 28 & min OI
BODN3G_H_T40		Target 40 & min OI
[Model Selector] BOST
BOST3G		Target 28
BOST3G_T40		Target 40
BOST3G_H		Target 28 & min OI
BOST3G_H_T40		Target 40 & min OI
[Model]   SATA_REFCLK_R
Model_type   Series
|   typ   min   max
C_comp   1fF   1fF   1fF
[Voltage Range]   1.200V   0.850V   1.550V
[Temperature Range]   25   125   -40
[R Series]   99.96ohm   110.9ohm   89.5ohm
| Models and submodels in the file (115): WBT_MDDR_08MA (I/O), WBT_MDDR_08MB (I/O), WBT_MDDR_10MA (I/O), WBT_MDDR_10MB (I/O), WBT_MSDR_10MA (I/O), WBT_MSDR_10MB (I/O), WOT_MDDR_08MA (3-state), WOT_MDDR_08MB (3-state), WOT_MDDR_10MA (3-state), WOT_MDDR_10MB (3-state), WOT_MSDR_10MA (3-state), WOT_MSDR_10MB (3-state), WOT_MDDR_07MA (3-state), WOT_MDDR_07MB (3-state), WOT_MDDR_09MA (3-state), WOT_MDDR_09MB (3-state), WOT_MSDR_09MA (3-state), WOT_MSDR_09MB (3-state), IO3_A (I/O), IO3_B (I/O), IO3_C (I/O), IO3_D (I/O), IO3_E (I/O), IO3_F (I/O), IO3_G (I/O), IO3_H (I/O), IO3_I (I/O), IO3_J (I/O), IO3_K (I/O), IO3_L (I/O), IO3_M (I/O), IO3_N (I/O), IO3_O (I/O), IO3_P (I/O), IO2_A (I/O), IO2_B (I/O), IO2_C (I/O), IO2_D (I/O), IO2_E (I/O), IO2_F (I/O), IO2_G (I/O), IO2_H (I/O), IO2_I (I/O), IO2_J (I/O), IO2_K (I/O), IO2_L (I/O), IO2_M (I/O), IO2_N (I/O), IO2_O (I/O), IO2_P (I/O), HSdriver_M (Output), HSdriver_P (Output), PCIE_TX_M (Output), PCIE_TX_B (Output), PCIE_RX (Terminator), PCIE_REFCLK (Input), SATA_TX_M (Output), SATA_TX_B (Output), SATA_RX (Terminator), SATA_REFCLK (Input), SATA_REFCLK_R (Series), BVRN3G (Input), BODN3G (Output), BODN3G_T40 (Output), BODN3G_H (Output), BODN3G_H_T40 (Output), BOST3G (I/O), BOST3G_T40 (I/O), BOST3G_H (I/O), BOST3G_H_T40 (I/O), BBST3G (I/O), BBST3G_H_ODT_S1 (Input), BBST3G_H_T40 (I/O), BBST3G_H_T40_ODT (Input), BBST3G_H_T40_ODT_S0 (Input), BBST3G_H_T40_ODT_S1 (Input), BBST3G_ODT (Input), BBST3G_ODT_S0 (Input), BBST3G_H (I/O), BBST3G_H_ODT (Input)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
