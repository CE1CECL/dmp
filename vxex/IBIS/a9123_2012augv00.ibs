[IBIS Ver]   3.2
[File Name]   a9123_2012augv00.ibs
[File Rev]   1.00
[Date]   08/29/2012
[Source]   From silicon level SPICE model
[Notes]
[Disclaimer]
|Use:RDC Semiconductor Co., Ltd. ("RDC") hereby grants the user of this
|IBIS model ("user") non-exclusive, nontransferable license to use the
|model under the following terms. User may only use the IBIS model and
|is not granted rights to sell, copy, rent, lease or sub-license the IBIS
|model in whole or in part, or in modified form to anyone.
|DISCLAIMER OF WARRANTY: ALL ACCOMPANYING MATERIALS ARE PROVIDED "AS IS",
|WITHOUT WARRANTY OF ANY KIND. TO THE MAXIMUM EXTENT PERMITTED BY LAW,
|RDC HEREBY DISCLAIMS ALL WARRANTIES, EXPRESS, IMPLIED AND STATUTORY,
|INCLUDING BUT NOT LIMITED TO, IMPLIED WARRANTIES OF MERCHANTABILITY AND
|FITNESS FOR A PARTICULAR PURPOSE (REGARDLESS OF WHETHER RDC KNOWS OF
|SUCH PURPOSE) AND AGAINST INFRINGEMENT. THE ENTIRE RISK ARISING OUT OF
|THE USE OR PERFORMANCE OF ANY ACCOMPANYING WRITTEN MATERIALS REMAINS
|WITH USER.
[Copyright]
|This file is the legal property of RDC Semiconductor Co., Ltd.. All other
|rights are reserved.
[Component]   a9123
[Manufacturer]  RDC Semiconductor Co., Ltd.
[Package]
|   typ   min   max
R_pkg	0.377	0.264	0.538
L_pkg	7.123nH	4.986nH	10.175nH
C_pkg	1.883pF	1.318pF	2.690pF
[Pin]	signal_name	model_name	R_pin	L_pin	C_pin
L1	SATA_EXTXOP		SATA_TX_M
L2	SATA_EXTXON		SATA_TX_M
K1	SATA_EARXIP		SATA_RX
K2	SATA_EARXIN		SATA_RX
J1	SATA_EAREFCLKP		SATA_REFCLK
J2	SATA_EAREFCLKN		SATA_REFCLK
R1	PCIe1_EXTXOP		PCIE_TX_M
R2	PCIe1_EXTXON		PCIE_TX_M
P1	PCIe1_EARXIP		PCIE_RX
P2	PCIe1_EARXIN		PCIE_RX
N2	PCIe1_EAREFCLKP		PCIE_REFCLK
N1	PCIe1_EAREFCLKN		PCIE_REFCLK
W10	pDQ8	DDR3_IO1
W11	pDQ9	DDR3_IO1
V10	pDQ10	DDR3_IO1
U10	pDQ11	DDR3_IO1
V13	pDM1	DDR3_IO1
V11	pDQS1	DDR3_IO3
W12	pDQS1_	DDR3_IO4
W14	pDQ12	DDR3_IO1
W15	pDQ13	DDR3_IO1
V16	pDQ14	DDR3_IO1
V15	pDQ15	DDR3_IO1
R10	pDQ00	DDR3_IO1
U11	pDQ01	DDR3_IO1
T11	pDQ02	DDR3_IO1
R11	pDQ03	DDR3_IO1
T13	pDM0	DDR3_IO1
U12	pDQS0	DDR3_IO3
U13	pDQS0_	DDR3_IO4
U14	pDQ04	DDR3_IO1
U15	pDQ05	DDR3_IO1
T14	pDQ06	DDR3_IO1
T15	pDQ07	DDR3_IO1
W17	pSDRAMCLK0	DDR3_IO5
W16	pSDRAMCLKN0	DDR3_IO6
V18	pRAS	DDR3_IO2
T18	pCAS	DDR3_IO2
P18	pWE	DDR3_IO2
W18	TEST_ODT0	DDR3_IO2
R13	TEST_ODT1	DDR3_IO2
U19	pCKE0	DDR3_IO2
V19	pCS0	DDR3_IO2
R14	pCS1	DDR3_IO2
L19	pMA0	DDR3_IO2
N15	pMA1	DDR3_IO2
U17	pMA2	DDR3_IO2
U16	pMA3	DDR3_IO2
N17	pMA4	DDR3_IO2
T16	pMA5	DDR3_IO2
L16	pMA6	DDR3_IO2
R17	pMA7	DDR3_IO2
M17	pMA8	DDR3_IO2
T17	pMA9	DDR3_IO2
T19	pMA10	DDR3_IO2
P17	pMA11	DDR3_IO2
P16	pMA12	DDR3_IO2
P15	pMA13	DDR3_IO2
N16	pMA14	DDR3_IO2
P19	pMA15	DDR3_IO2
L18	pBA0	DDR3_IO2
N18	pBA1	DDR3_IO2
N19	pBA2	DDR3_IO2
L17	pRST	DDR3_IO7
L15	pPORT8[0]	5VTOL_IO1
K16	pPORT8[1]	5VTOL_IO1
K17	pPORT8[2]	5VTOL_IO1
J19	pPORT8[3]	5VTOL_IO1
J18	pPORT8[4]	5VTOL_IO1
J16	pPORT8[5]	5VTOL_IO1
J15	pPORT8[6]	5VTOL_IO1
J17	pPORT8[7]	5VTOL_IO1
H19	pPORT1[0]	5VTOL_IO1
H18	pPORT1[1]	5VTOL_IO1
H16	pPORT1[2]	5VTOL_IO1
G19	pPORT1[3]	5VTOL_IO1
G18	pPORT1[4]	5VTOL_IO1
G17	pPORT1[5]	5VTOL_IO1
H15	pPORT1[6]	5VTOL_IO1
G16	pPORT1[7]	5VTOL_IO1
F19	pPORT2[0]	5VTOL_IO1
E19	pPORT2[1]	5VTOL_IO1
F17	pPORT2[2]	5VTOL_IO1
E18	pPORT2[3]	5VTOL_IO1
F16	pPORT2[4]	5VTOL_IO1
E16	pPORT2[5]	5VTOL_IO1
E15	pPORT2[6]	5VTOL_IO1
F15	pPORT2[7]	5VTOL_IO1
D19	pPORT3[0]	5VTOL_IO1
C19	pPORT3[1]	5VTOL_IO1
D18	pPORT3[2]	5VTOL_IO1
B19	pPORT3[3]	5VTOL_IO1
D17	pPORT3[4]	5VTOL_IO1
D16	pPORT3[5]	5VTOL_IO1
C17	pPORT3[6]	5VTOL_IO1
C16	pPORT3[7]	5VTOL_IO1
D15	pPORT4[0]	5VTOL_IO1
E14	pPORT4[1]	5VTOL_IO1
B18	pPORT4[2]	5VTOL_IO1
A18	pPORT4[3]	5VTOL_IO1
C15	pPORT4[4]	5VTOL_IO1
A17	pPORT4[5]	5VTOL_IO1
B16	pPORT4[6]	5VTOL_IO1
A16	pPORT4[7]	5VTOL_IO1
D14	pPORT5[0]	5VTOL_IO1
A15	pPORT5[1]	5VTOL_IO1
B14	pPORT5[2]	5VTOL_IO1
A14	pPORT5[3]	5VTOL_IO1
D13	pPORT5[4]	5VTOL_IO1
E12	pPORT5[5]	5VTOL_IO1
C13	pPORT5[6]	5VTOL_IO1
D12	pPORT5[7]	5VTOL_IO1
B13	pPORT6[0]	5VTOL_IO1
A13	pPORT6[1]	5VTOL_IO1
A12	pPORT6[2]	5VTOL_IO1
E11	pPORT6[3]	5VTOL_IO1
B12	pPORT6[4]	5VTOL_IO1
C12	pPORT6[5]	5VTOL_IO1
D11	pPORT6[6]	5VTOL_IO1
C11	pPORT6[7]	5VTOL_IO1
A11	pPORT7[0]	5VTOL_IO1
B11	pPORT7[1]	5VTOL_IO1
A9	pPORT7[2]	5VTOL_IO1
A10	pPORT7[3]	5VTOL_IO1
B9	pPORT7[4]	5VTOL_IO1
B10	pPORT7[5]	5VTOL_IO1
D10	pPORT7[6]	5VTOL_IO1
D9	pPORT7[7]	5VTOL_IO1
C8	pPORT0[0]	5VTOL_IO1
D7	pPORT0[1]	5VTOL_IO1
B8	pPORT0[2]	5VTOL_IO1
A8	pPORT0[3]	5VTOL_IO1
C9	pPORT0[4]	5VTOL_IO1
E9	pPORT0[5]	5VTOL_IO1
D8	pPORT0[6]	5VTOL_IO1
E8	pPORT0[7]	5VTOL_IO1
C6	pPORT9[0]	5VTOL_IO1
B7	pPORT9[1]	5VTOL_IO1
D6	pPORT9[2]	5VTOL_IO1
B6	pPORT9[3]	5VTOL_IO1
C5	pPORT9[4]	5VTOL_IO1
A7	pPORT9[5]	5VTOL_IO1
A6	pPORT9[6]	5VTOL_IO1
A5	pPORT9[7]	5VTOL_IO1
E5	pTCK_0	5VTOL_IO1
E7	pTDI_0	5VTOL_IO1
E6	pTDO_0	5VTOL_IO1
G4	pTMS_0	5VTOL_IO1
B5	pPOWER_GOOD	5VTOL_IO1
A4	pISA_RST	5VTOL_IO1
A3	pPCIRST_	5VTOL_33
B2	USB2_DM		HSdriver_M
B1	USB2_DP		HSdriver_P
D2	USB1_DM		HSdriver_M
D1	USB1_DP		HSdriver_P
F4	pSPI_CS	IO18
E4	pSPI_CK	IO18
H5	pSPI_DI	IO18
G5	pSPI_DO	IO18
D5	pPCIE_MSEL	IO18
[Diff Pin] inv_pin  vdiff   tdelay_typ tdelay_min tdelay_max
| PCIE
R1   R2   NA   0   0   0
P1   P2   NA   0   0   0
N2   N1   NA   0   0   0
| SATA
L1   L2   NA   0   0   0
K1   K2   NA   0   0   0
J1   J2   NA   0   0   0
| USB
B2   B1   360mV   0n   NA   NA
D2   D1   360mV   0n   NA   NA
[Model Selector] 5VTOL_33
IOY32B33XXX01_A   IOL=4mA , FAST slew rate, Normal Input
IOY32B33XXX01_B   IOL=4mA , SLOW slew rate, Normal Input
IOY32B33XXX01_C   IOL=8mA , FAST slew rate, Normal Input
IOY32B33XXX01_D   IOL=8mA , SLOW slew rate, Normal Input
IOY32B33XXX01_E   IOL=12mA, FAST slew rate, Normal Input
IOY32B33XXX01_F   IOL=12mA, SLOW slew rate, Normal Input
IOY32B33XXX01_G   IOL=16mA, FAST slew rate, Normal Input
IOY32B33XXX01_H   IOL=16mA, SLOW slew rate, Normal Input
IOY32B33XXX01_I   IOL=4mA , FAST slew rate, Schmitt Input
IOY32B33XXX01_J   IOL=4mA , SLOW slew rate, Schmitt Input
IOY32B33XXX01_K   IOL=8mA , FAST slew rate, Schmitt Input
IOY32B33XXX01_L   IOL=8mA , SLOW slew rate, Schmitt Input
IOY32B33XXX01_M   IOL=12mA, FAST slew rate, Schmitt Input
IOY32B33XXX01_N   IOL=12mA, SLOW slew rate, Schmitt Input
IOY32B33XXX01_O   IOL=16mA, FAST slew rate, Schmitt Input
IOY32B33XXX01_P   IOL=16mA, SLOW slew rate, Schmitt Input
[Model Selector] 5VTOL_IO1
IOY32B5VTOL01_A   IOL=4mA , FAST slew rate, Normal Input
IOY32B5VTOL01_B   IOL=4mA , SLOW slew rate, Normal Input
IOY32B5VTOL01_C   IOL=8mA , FAST slew rate, Normal Input
IOY32B5VTOL01_D   IOL=8mA , SLOW slew rate, Normal Input
IOY32B5VTOL01_E   IOL=12mA, FAST slew rate, Normal Input
IOY32B5VTOL01_F   IOL=12mA, SLOW slew rate, Normal Input
IOY32B5VTOL01_G   IOL=16mA, FAST slew rate, Normal Input
IOY32B5VTOL01_H   IOL=16mA, SLOW slew rate, Normal Input
IOY32B5VTOL01_I   IOL=4mA , FAST slew rate, Schmitt Input
IOY32B5VTOL01_J   IOL=4mA , SLOW slew rate, Schmitt Input
IOY32B5VTOL01_K   IOL=8mA , FAST slew rate, Schmitt Input
IOY32B5VTOL01_L   IOL=8mA , SLOW slew rate, Schmitt Input
IOY32B5VTOL01_M   IOL=12mA, FAST slew rate, Schmitt Input
IOY32B5VTOL01_N   IOL=12mA, SLOW slew rate, Schmitt Input
IOY32B5VTOL01_O   IOL=16mA, FAST slew rate, Schmitt Input
IOY32B5VTOL01_P   IOL=16mA, SLOW slew rate, Schmitt Input
[Model Selector] IO18
IOMFCWBT_MDDR_08MA  MDDR  8mA VDD=1.0V VDE=1.8V
IOMFCWBT_MDDR_10MA  MDDR 10mA VDD=1.0V VDE=1.8V
IOMFCWBT_MSDR_10MA  MSDR 10mA VDD=1.0V VDE=2.5V
IOMFCWBT_MDDR_08MB  MDDR  8mA VDD=1.2V VDE=1.8V
IOMFCWBT_MDDR_10MB  MDDR 10mA VDD=1.2V VDE=1.8V
IOMFCWBT_MSDR_10MB  MSDR 10mA VDD=1.2V VDE=2.5V
[Model Selector] IO18_2
IOMFCWOT_MDDR_08MA  MDDR  8mA VDD=1.0V VDE=1.8V
IOMFCWOT_MDDR_10MA  MDDR 10mA VDD=1.0V VDE=1.8V
IOMFCWOT_MSDR_10MA  MSDR 10mA VDD=1.0V VDE=2.5V
IOMFCWOT_MDDR_08MB  MDDR  8mA VDD=1.2V VDE=1.8V
IOMFCWOT_MDDR_10MB  MDDR 10mA VDD=1.2V VDE=1.8V
IOMFCWOT_MSDR_10MB  MSDR 10mA VDD=1.2V VDE=2.5V
[Model Selector] IO18_3
IOMFCWOT_MDDR_07MA  MDDR  7mA VDD=1.0V VDE=1.8V
IOMFCWOT_MDDR_09MA  MDDR  9mA VDD=1.0V VDE=1.8V
IOMFCWOT_MSDR_09MA  MSDR  9mA VDD=1.0V VDE=2.5V
IOMFCWOT_MDDR_07MB  MDDR  7mA VDD=1.2V VDE=1.8V
IOMFCWOT_MDDR_09MB  MDDR  9mA VDD=1.2V VDE=1.8V
IOMFCWOT_MSDR_09MB  MSDR  9mA VDD=1.2V VDE=2.5V
[Model Selector]  DDR3_IO1
IOSSC1BS01_DDR3_120   DDR3, Input,   ODT= 120ohm, RZQ off   , VDD=1.2V
IOSSC1BS01_DDR3_060   DDR3, Input,   ODT=  60ohm, RZQ off   , VDD=1.2V
IOSSC1BS01_DDR3_040   DDR3, Input,   ODT=  40ohm, RZQ off   , VDD=1.2V
IOSSC1BS01_DDR3_Z60   DDR3, I/O  ,   ODT off   , RZQ=  60ohm, VDD=1.2V
IOSSC1BS01_DDR3_Z48   DDR3, I/O  ,   ODT off   , RZQ=  48ohm, VDD=1.2V
IOSSC1BS01_DDR3_Z40   DDR3, I/O  ,   ODT off   , RZQ=  40ohm, VDD=1.2V
IOSSC1BS01_DDR3_Z34   DDR3, I/O  ,   ODT off   , RZQ=  34ohm, VDD=1.2V
IOSSC1BS01_DDR2_100   DDR2, Input,   ODT= 100ohm, RZQ off   , VDD=1.2V
IOSSC1BS01_DDR2_050   DDR2, Input,   ODT=  50ohm, RZQ off   , VDD=1.2V
IOSSC1BS01_DDR2_033   DDR2, Input,   ODT=  33ohm, RZQ off   , VDD=1.2V
IOSSC1BS01_DDR2_Z50   DDR2, I/O  ,   ODT off   , RZQ=  50ohm, VDD=1.2V
IOSSC1BS01_DDR2_Z40   DDR2, I/O  ,   ODT off   , RZQ=  40ohm, VDD=1.2V
IOSSC1BS01_DDR2_Z33   DDR2, I/O  ,   ODT off   , RZQ=  33ohm, VDD=1.2V
IOSSC1BS01_DDR2_Z28   DDR2, I/O  ,   ODT off   , RZQ=  28ohm, VDD=1.2V
[Model Selector]  DDR3_IO4
IOSSF1BD01_DDR3_120N  DDR3, Input, Nega, ODT= 120ohm, RZQ off   , VDD=1.2V
IOSSF1BD01_DDR3_060N  DDR3, Input, Nega, ODT=  60ohm, RZQ off   , VDD=1.2V
IOSSF1BD01_DDR3_040N  DDR3, Input, Nega, ODT=  40ohm, RZQ off   , VDD=1.2V
IOSSF1BD01_DDR3_Z60N  DDR3, I/O  , Nega, ODT off   , RZQ=  60ohm, VDD=1.2V
IOSSF1BD01_DDR3_Z48N  DDR3, I/O  , Nega, ODT off   , RZQ=  48ohm, VDD=1.2V
IOSSF1BD01_DDR3_Z40N  DDR3, I/O  , Nega, ODT off   , RZQ=  40ohm, VDD=1.2V
IOSSF1BD01_DDR3_Z34N  DDR3, I/O  , Nega, ODT off   , RZQ=  34ohm, VDD=1.2V
IOSSF1BD01_DDR2_100N  DDR2, Input, Nega, ODT= 100ohm, RZQ off   , VDD=1.2V
IOSSF1BD01_DDR2_050N  DDR2, Input, Nega, ODT=  50ohm, RZQ off   , VDD=1.2V
IOSSF1BD01_DDR2_033N  DDR2, Input, Nega, ODT=  33ohm, RZQ off   , VDD=1.2V
IOSSF1BD01_DDR2_Z50N  DDR2, I/O  , Nega, ODT off   , RZQ=  50ohm, VDD=1.2V
IOSSF1BD01_DDR2_Z40N  DDR2, I/O  , Nega, ODT off   , RZQ=  40ohm, VDD=1.2V
IOSSF1BD01_DDR2_Z33N  DDR2, I/O  , Nega, ODT off   , RZQ=  33ohm, VDD=1.2V
IOSSF1BD01_DDR2_Z28N  DDR2, I/O  , Nega, ODT off   , RZQ=  28ohm, VDD=1.2V
[Model Selector]  DDR3_IO3
IOSSF1BD01_DDR3_120P  DDR3, Input, Posi, ODT= 120ohm, RZQ off   , VDD=1.2V
IOSSF1BD01_DDR3_060P  DDR3, Input, Posi, ODT=  60ohm, RZQ off   , VDD=1.2V
IOSSF1BD01_DDR3_040P  DDR3, Input, Posi, ODT=  40ohm, RZQ off   , VDD=1.2V
IOSSF1BD01_DDR3_Z60P  DDR3, I/O  , Posi, ODT off   , RZQ=  60ohm, VDD=1.2V
IOSSF1BD01_DDR3_Z48P  DDR3, I/O  , Posi, ODT off   , RZQ=  48ohm, VDD=1.2V
IOSSF1BD01_DDR3_Z40P  DDR3, I/O  , Posi, ODT off   , RZQ=  40ohm, VDD=1.2V
IOSSF1BD01_DDR3_Z34P  DDR3, I/O  , Posi, ODT off   , RZQ=  34ohm, VDD=1.2V
IOSSF1BD01_DDR2_100P  DDR2, Input, Posi, ODT= 100ohm, RZQ off   , VDD=1.2V
IOSSF1BD01_DDR2_050P  DDR2, Input, Posi, ODT=  50ohm, RZQ off   , VDD=1.2V
IOSSF1BD01_DDR2_033P  DDR2, Input, Posi, ODT=  33ohm, RZQ off   , VDD=1.2V
IOSSF1BD01_DDR2_Z50P  DDR2, I/O  , Posi, ODT off   , RZQ=  50ohm, VDD=1.2V
IOSSF1BD01_DDR2_Z40P  DDR2, I/O  , Posi, ODT off   , RZQ=  40ohm, VDD=1.2V
IOSSF1BD01_DDR2_Z33P  DDR2, I/O  , Posi, ODT off   , RZQ=  33ohm, VDD=1.2V
IOSSF1BD01_DDR2_Z28P  DDR2, I/O  , Posi, ODT off   , RZQ=  28ohm, VDD=1.2V
[Model Selector]  DDR3_IO2
IOSSC1OS01_DDR3_Z60   DDR3, I/O  ,   RZQ=  60ohm, VDD=1.2V
IOSSC1OS01_DDR3_Z48   DDR3, I/O  ,   RZQ=  48ohm, VDD=1.2V
IOSSC1OS01_DDR3_Z40   DDR3, I/O  ,   RZQ=  40ohm, VDD=1.2V
IOSSC1OS01_DDR3_Z34   DDR3, I/O  ,   RZQ=  34ohm, VDD=1.2V
IOSSC1OS01_DDR2_Z50   DDR2, I/O  ,   RZQ=  50ohm, VDD=1.2V
IOSSC1OS01_DDR2_Z40   DDR2, I/O  ,   RZQ=  40ohm, VDD=1.2V
IOSSC1OS01_DDR2_Z33   DDR2, I/O  ,   RZQ=  33ohm, VDD=1.2V
IOSSC1OS01_DDR2_Z28   DDR2, I/O  ,   RZQ=  28ohm, VDD=1.2V
[Model Selector]  DDR3_IO6
IOSSF1OD01_DDR3_Z60N  DDR3, I/O  , Nega, RZQ=  60ohm, VDD=1.2V
IOSSF1OD01_DDR3_Z48N  DDR3, I/O  , Nega, RZQ=  48ohm, VDD=1.2V
IOSSF1OD01_DDR3_Z40N  DDR3, I/O  , Nega, RZQ=  40ohm, VDD=1.2V
IOSSF1OD01_DDR3_Z34N  DDR3, I/O  , Nega, RZQ=  34ohm, VDD=1.2V
IOSSF1OD01_DDR2_Z50N  DDR2, I/O  , Nega, RZQ=  50ohm, VDD=1.2V
IOSSF1OD01_DDR2_Z40N  DDR2, I/O  , Nega, RZQ=  40ohm, VDD=1.2V
IOSSF1OD01_DDR2_Z33N  DDR2, I/O  , Nega, RZQ=  33ohm, VDD=1.2V
IOSSF1OD01_DDR2_Z28N  DDR2, I/O  , Nega, RZQ=  28ohm, VDD=1.2V
[Model Selector]  DDR3_IO5
IOSSF1OD01_DDR3_Z60P  DDR3, I/O  , Posi, RZQ=  60ohm, VDD=1.2V
IOSSF1OD01_DDR3_Z48P  DDR3, I/O  , Posi, RZQ=  48ohm, VDD=1.2V
IOSSF1OD01_DDR3_Z40P  DDR3, I/O  , Posi, RZQ=  40ohm, VDD=1.2V
IOSSF1OD01_DDR3_Z34P  DDR3, I/O  , Posi, RZQ=  34ohm, VDD=1.2V
IOSSF1OD01_DDR2_Z50P  DDR2, I/O  , Posi, RZQ=  50ohm, VDD=1.2V
IOSSF1OD01_DDR2_Z40P  DDR2, I/O  , Posi, RZQ=  40ohm, VDD=1.2V
IOSSF1OD01_DDR2_Z33P  DDR2, I/O  , Posi, RZQ=  33ohm, VDD=1.2V
IOSSF1OD01_DDR2_Z28P  DDR2, I/O  , Posi, RZQ=  28ohm, VDD=1.2V
[Model Selector]  DDR3_IO7
IOSSC1RE01_DDR3  DDR3, Output, VDD=1.2V
IOSSC1RE01_DDR2  DDR2, Output, VDD=1.2V
[Model]   SATA_REFCLK_R
Model_type   Series
|   typ   min   max
C_comp   1fF   1fF   1fF
[Voltage Range]   1.200V   0.850V   1.550V
[Temperature Range]   25   125   -40
[R Series]   99.96ohm   110.9ohm   89.5ohm
| Models and submodels in the file (129): SATA_TX_M (Output), SATA_TX_B (Output), SATA_RX (Terminator), SATA_REFCLK (Input), SATA_REFCLK_R (Series), PCIE_TX_M (Output), PCIE_TX_B (Output), PCIE_RX (Terminator), PCIE_REFCLK (Input), HSdriver_M (Output), HSdriver_P (Output), IOY32B33XXX01_A (I/O), IOY32B33XXX01_B (I/O), IOY32B33XXX01_C (I/O), IOY32B33XXX01_D (I/O), IOY32B33XXX01_E (I/O), IOY32B33XXX01_F (I/O), IOY32B33XXX01_G (I/O), IOY32B33XXX01_H (I/O), IOY32B33XXX01_I (I/O), IOY32B33XXX01_J (I/O), IOY32B33XXX01_K (I/O), IOY32B33XXX01_L (I/O), IOY32B33XXX01_M (I/O), IOY32B33XXX01_N (I/O), IOY32B33XXX01_O (I/O), IOY32B33XXX01_P (I/O), IOY32B5VTOL01_A (I/O), IOY32B5VTOL01_B (I/O), IOY32B5VTOL01_C (I/O), IOY32B5VTOL01_D (I/O), IOY32B5VTOL01_E (I/O), IOY32B5VTOL01_F (I/O), IOY32B5VTOL01_G (I/O), IOY32B5VTOL01_H (I/O), IOY32B5VTOL01_I (I/O), IOY32B5VTOL01_J (I/O), IOY32B5VTOL01_K (I/O), IOY32B5VTOL01_L (I/O), IOY32B5VTOL01_M (I/O), IOY32B5VTOL01_N (I/O), IOY32B5VTOL01_O (I/O), IOY32B5VTOL01_P (I/O), IOMFCWBT_MDDR_08MA (I/O), IOMFCWBT_MDDR_08MB (I/O), IOMFCWBT_MDDR_10MA (I/O), IOMFCWBT_MDDR_10MB (I/O), IOMFCWBT_MSDR_10MA (I/O), IOMFCWBT_MSDR_10MB (I/O), IOMFCWOT_MDDR_08MA (3-state), IOMFCWOT_MDDR_08MB (3-state), IOMFCWOT_MDDR_10MA (3-state), IOMFCWOT_MDDR_10MB (3-state), IOMFCWOT_MSDR_10MA (3-state), IOMFCWOT_MSDR_10MB (3-state), IOMFCWOT_MDDR_07MA (3-state), IOMFCWOT_MDDR_07MB (3-state), IOMFCWOT_MDDR_09MA (3-state), IOMFCWOT_MDDR_09MB (3-state), IOMFCWOT_MSDR_09MA (3-state), IOMFCWOT_MSDR_09MB (3-state), IOSSC1BS01_DDR3_040 (Input), IOSSC1BS01_DDR3_060 (Input), IOSSC1BS01_DDR3_120 (Input), IOSSC1BS01_DDR3_Z34 (I/O), IOSSC1BS01_DDR3_Z40 (I/O), IOSSC1BS01_DDR3_Z48 (I/O), IOSSC1BS01_DDR3_Z60 (I/O), IOSSC1OS01_DDR3_Z34 (3-state), IOSSC1OS01_DDR3_Z40 (3-state), IOSSC1OS01_DDR3_Z48 (3-state), IOSSC1OS01_DDR3_Z60 (3-state), IOSSC1RE01_DDR3 (Output), IOSSF1BD01_DDR3_040N (Input), IOSSF1BD01_DDR3_040P (Input), IOSSF1BD01_DDR3_060N (Input), IOSSF1BD01_DDR3_060P (Input), IOSSF1BD01_DDR3_120N (Input), IOSSF1BD01_DDR3_120P (Input), IOSSF1BD01_DDR3_Z34N (I/O)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
